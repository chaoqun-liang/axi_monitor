// Copyright 2024 ETH Zurich and University of Bologna.
// Solderpad Hardware License, Version 0.51, see LICENSE for details.
// SPDX-License-Identifier: SHL-0.51
// Licensed under Solderpad Hardware License, Version 0.51, see LICENSE for details.


{
  name: "slv_guard"
  clock_primary: "clk_i"
  bus_interfaces: [
    { protocol: "reg_iface", direction: "device" }
  ]
  regwidth: "32",
  registers: [
  { name:     "guard_enable"
    desc:     "Enable slave guard feature"
    swaccess: "rw"
    hwaccess: "hrw"
    resval:   "0"
    fields: [
      { bits: "0:0", name: "enable", desc: "Enable slave guard feature" }
    ]
  },
    
  { name:     "budget_awvld_awrdy"
    desc:     "time budget from awvld to awrdy"
    swaccess: "wo"
    hwaccess: "hrw"
    resval:   "0"
    fields: [
      { bits: "3:0", name: "budget_awvld_awrdy", desc: "time budget from awvld to awrdy" }
    ]
  },
  
  { name:     "budget_unit_w"
    desc:     "time budget for unit length on w channel"
    swaccess: "wo"
    hwaccess: "hrw"
    resval:   "0"
    fields: [
      { bits: "1:0", name: "unit_budget_w", desc: "unit budget time on w channel" }
    ]
  },

  { name:     "budget_wvld_wrdy"
    desc:     "time budget from wvld to wrdy"
    swaccess: "wo"
    hwaccess: "hrw"
    resval:   "0"
    fields: [
      { bits: "3:0", name: "budget_wvld_wrdy", desc: "time budget from wvld to wrdy" }
    ]
  }

  { name:     "budget_wlast_bvld"
    desc:     "time budget from wlast to bvld"
    swaccess: "wo"
    hwaccess: "hrw"
    resval:   "0"
    fields: [
      { bits: "3:0", name: "budget_wlast_bvld", desc: "time budget from wlast to bvld" }
    ]
  },

  { name:     "budget_bvld_brdy"
    desc:     "time budget from bvld to brdy"
    swaccess: "wo"
    hwaccess: "hrw"
    resval:   "0"
    fields: [
      { bits: "3:0", name: "budget_bvld_brdy", desc: "time budget from bvld to brdy" }
    ]
  },

  { name:     "budget_arvld_arrdy"
    desc:     "time budget from arvld to arrdy"
    swaccess: "wo"
    hwaccess: "hrw"
    resval:   "0"
    fields: [
      { bits: "3:0", name: "budget_arvld_arrdy", desc: "time budget from arvld to arrdy" }
    ]
  },
  
  { name:     "budget_unit_r"
    desc:     "time budget for unit length on r channel"
    swaccess: "wo"
    hwaccess: "hrw"
    resval:   "0"
    fields: [
      { bits: "1:0", name: "unit_budget_r", desc: "unit budget time on read data channel" }
    ]
  },

  { name:     "budget_rvld_rrdy"
    desc:     "time budget from rvld to rrdy"
    swaccess: "wo"
    hwaccess: "hrw"
    resval:   "0"
    fields: [
      { bits: "3:0", name: "budget_rvld_rrdy", desc: "time budget from rvld to rrdy" }
    ]
  },
   
  { name:     "reset"
    desc:     "Is this slave device requested to be reset?"
    swaccess: "ro"
    hwaccess: "hrw"
    resval:   "0"
    fields: [
      { bits: "0:0", name: "reset", 
        desc: "Is this slave device requested to be reset?"  
      }
    ]
  },

  { name: "irq",
          desc: "interrpt cause",
          swaccess: "rw",
          hwaccess: "hrw",
          fields: [
              { bits: "0", name: "irq",
                desc: "interrupt raised by faulty transaction"
                resval: "0"
              },
              { bits: "1", name: "w0",
                desc: "timeout at w0 phase AWVALID to AWREADY"
                resval: "0"
              },
              { bits: "2", name: "w1",
                desc: "timeout at w1 phase AWVALID to WVALID"
                resval: "0"
              },
              { bits: "3", name: "w2",
                desc: "timeout at w2 phase WVALID to WREADY "
                resval: "0"
              },
              { bits: "4", name: "w3",
                desc: "timeout at w3 phase WVALID to WLAST"
                resval: "0"
              },
              { bits: "5", name: "w4",
                desc: "timeout at w4 phase WLAST to BVALID"
                resval: "0"
              },
              { bits: "6", name: "w5",
                desc: "timeout at w5 phase BVALID to BREADY"
                resval: "0"
              },
              { bits: "7", name: "r0",
                desc: "timeout at r0 phase ARVALID to ARREADY"
                resval: "0"
              },
              { bits: "8", name: "r1",
                desc: "timeout at r1 phase ARVALID to RVALID"
                resval: "0"
              },
              { bits: "9", name: "r2",
                desc: "timeout at r2 phase RVALID to RREADY"
                resval: "0"
              },
              { bits: "10", name: "r3",
                desc: "timeout at r3 phase RVALID to RLAST"
                resval: "0"
              },
              { bits: "11", name: "unwanted_wr_resp",
                desc: "  this write response is unexpected "
                resval: "0"
              },
              { bits: "12", name: "unwanted_rd_resp",
                desc: "  this read response is unexpected "
                resval: "0"
              },
              { bits: "24:13", name: "txn_id",
                desc: "id of the faulty transaction"
                resval: "0"
              }
          ]
  },

  { name:     "irq_addr"
    desc:     "address of the faulty transaction"
    swaccess: "ro"
    hwaccess: "hrw"
    resval:   "0"
    fields: [
      { bits: "31:0", name: "irq_addr", desc: "address of the faulty transaction" }
    ]
  },
  

  { name:     "latency_awvld_awrdy"
    desc:     "letency from awvld to awrdy"
    swaccess: "ro"
    hwaccess: "hrw"
    resval:   "0"
    fields: [
      { bits: "9:0", name: "latency_awvld_awrdy", desc: "latency from awvld to awrdy" }
    ]
  },
  
  { name:     "latency_awvld_wfirst"
    desc:     "latency from awvld to wfirst"
    swaccess: "ro"
    hwaccess: "hrw"
    resval:   "0"
    fields: [
      { bits: "9:0", name: "latency_awvld_wfirst", desc: "latency from awvld to wfirst" }
    ]
  },

  { name:     "latency_wvld_wrdy"
    desc:     "latency from wvld to wrdy"
    swaccess: "ro"
    hwaccess: "hrw"
    resval:   "0"
    fields: [
      { bits: "9:0", name: "latency_wvld_wrdy", desc: "latency from wvld to wrdy" }
    ]
  }

  { name:     "latency_wvld_wlast"
    desc:     "latency from wvld to wlast"
    swaccess: "ro"
    hwaccess: "hrw"
    resval:   "0"
    fields: [
      { bits: "9:0", name: "latency_wvld_wlast", desc: "latency from wvld to wlast" }
    ]
  },

  { name:     "latency_wlast_bvld"
    desc:     "latency from wlast to bvld"
    swaccess: "ro"
    hwaccess: "hrw"
    resval:   "0"
    fields: [
      { bits: "9:0", name: "latency_wlast_bvld", desc: "latency from wlast to bvld" }
    ]
  },

  { name:     "latency_bvld_brdy"
    desc:     "latency from bvld to brdy"
    swaccess: "ro"
    hwaccess: "hrw"
    resval:   "0"
    fields: [
      { bits: "9:0", name: "latency_wlast_brdy", desc: "latency from wlast to brdy" }
    ]
  },

  { name:     "latency_arvld_arrdy"
    desc:     "latency from arvld to arrdy"
    swaccess: "ro"
    hwaccess: "hrw"
    resval:   "0"
    fields: [
      { bits: "9:0", name: "latency_arvld_arrdy", desc: "latency from arvld to arrdy" }
    ]
  },
  
  { name:     "latency_arvld_rvld"
    desc:     "latency from arvld to rvld"
    swaccess: "ro"
    hwaccess: "hrw"
    resval:   "0"
    fields: [
      { bits: "9:0", name: "latency_arvld_rvld", desc: "latency from arvld to rvld" }
    ]
  },

  { name:     "latency_rvld_rrdy"
    desc:     "latency from rvld to rrdy"
    swaccess: "ro"
    hwaccess: "hrw"
    resval:   "0"
    fields: [
      { bits: "9:0", name: "latency_rvld_rrdy", desc: "latency from rvld to rrdy" }
    ]
  },

  { name:     "latency_rvld_rlast"
    desc:     "latency from rvld to rlast"
    swaccess: "ro"
    hwaccess: "hrw"
    resval:   "0"
    fields: [
      { bits: "9:0", name: "latency_rvld_rlast", desc: "latency from rvld to rlast" }
    ]
  },
  ]
}
