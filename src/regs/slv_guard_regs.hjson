// Copyright 2024 ETH Zurich and University of Bologna.
// Solderpad Hardware License, Version 0.51, see LICENSE for details.
// SPDX-License-Identifier: SHL-0.51
// Licensed under Solderpad Hardware License, Version 0.51, see LICENSE for details.


{
  name: "slv_guard"
  clock_primary: "clk_i"
  bus_interfaces: [
    { protocol: "reg_if", direction: "device" }
  ],
  regwidth: 32
  
  { name:     "guard_enable"
    desc:     "Enable slave guard feature"
    swaccess: "wo"
    hwaccess: "hro"
    resval:   "0"
    fields: [
      { bits: "0:0", name: "enable", desc: "Enable slave guard feature" }
    ]
  }
    
  { name:     "budget_awvld_awrdy"
    desc:     "time budget from awvld to awrdy"
    swaccess: "wo"
    hwaccess: "hro"
    resval:   "0"
    fields: [
      { bits: "9:0", name: "budget_awvld_awrdy", desc: "time budget from awvld to awrdy" }
    ]
  }
  
  { name:     "budget_awvld_wvld"
    desc:     "time budget from awvld to wvld"
    swaccess: "wo"
    hwaccess: "hro"
    resval:   "0"
    fields: [
      { bits: "9:0", name: "budget_awvld_wvld", desc: "time budget from awvld to wvld" }
    ]
  }

  { name:     "budget_wvld_wrdy"
    desc:     "time budget from wvld to wrdy"
    swaccess: "wo"
    hwaccess: "hro"
    resval:   "0"
    fields: [
      { bits: "9:0", name: "budget_wvld_wrdy", desc: "time budget from wvld to wrdy" }
    ]
  }

  { name:     "budget_wvld_wlast"
    desc:     "time budget from wvld to wlast"
    swaccess: "wo"
    hwaccess: "hro"
    resval:   "0"
    fields: [
      { bits: "9:0", name: "budget_wvld_wlast", desc: "time budget from wvld to wlast" }
    ]
  }

  { name:     "budget_wlast_bvld"
    desc:     "time budget from wlast to bvld"
    swaccess: "wo"
    hwaccess: "hro"
    resval:   "0"
    fields: [
      { bits: "9:0", name: "budget_wlast_bvld", desc: "time budget from wlast to bvld" }
    ]
  }

  { name:     "budget_wlast_brdy"
    desc:     "time budget from wlast to brdy"
    swaccess: "wo"
    hwaccess: "hro"
    resval:   "0"
    fields: [
      { bits: "9:0", name: "budget_wlast_brdy", desc: "time budget from wlast to brdy" }
    ]
  }

  { name:     "budget_arvld_arrdy"
    desc:     "time budget from arvld to arrdy"
    swaccess: "wo"
    hwaccess: "hro"
    resval:   "0"
    fields: [
      { bits: "9:0", name: "budget_arvld_arrdy", desc: "time budget from arvld to arrdy" }
    ]
  }
  
  { name:     "budget_arvld_rvld"
    desc:     "time budget from arvld to rvld"
    swaccess: "wo"
    hwaccess: "hro"
    resval:   "0"
    fields: [
      { bits: "9:0", name: "budget_arvld_rvld", desc: "time budget from arvld to rvld" }
    ]
  }

  { name:     "budget_rvld_rrdy"
    desc:     "time budget from rvld to rrdy"
    swaccess: "wo"
    hwaccess: "hro"
    resval:   "0"
    fields: [
      { bits: "9:0", name: "budget_rvld_rrdy", desc: "time budget from rvld to rrdy" }
    ]
  }

  { name:     "budget_rvld_rlast"
    desc:     "time budget from rvld to rlast"
    swaccess: "wo"
    hwaccess: "hro"
    resval:   "0"
    fields: [
      { bits: "9:0", name: "budget_rvld_rlast", desc: "time budget from rvld to rlast" }
    ]
  }
   
  { name:     "reset"
    desc:     "Is the interface requested to be reset?"
    swaccess: "ro"
    hwaccess: "hwo"
    fields: [
      { bits: "0:0", name: "reset", desc: "Is the interface requested to be reset?" }
    ]
  }

  { name: "irq",
          desc: "interrpt cause and clear",
          swaccess: "rw",
          hwaccess: "hwo",
          fields: [
              { bits: "0", name: "irq_cause",
                desc: "timeout 0 and id_mismatch 1"
                resval: "0"
              },
              { bits: "6:1", name: "txn_id",
                desc: "id of the transaction going wrong"
              },
              { bits: "7", name: "irq clear",
                desc: "MDIO clock"
              }
          ]
  },
 
  { name:     "max_txns_write"
    desc:     "Value of the maximum outstanding write transactions."
    swaccess: "ro"
    swaccess: "hwo"
    resval:   "8"
    fields: [
      { bits: "31:0", name: "max_txns_write", desc: "Value of the maximum outstanding write transactions." }
    ]
  }

  { name:     "max_txns_read"
    desc:     "Value of the maximum outstanding write transactions."
    swaccess: "ro"
    swaccess: "hwo"
    resval:   "8"
    fields: [
      { bits: "31:0", name: "max_txns_read", desc: "Value of the maximum outstanding read transactions." }
    ]
  }

  ]
}

